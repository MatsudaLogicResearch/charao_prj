**===================================================================
** This file is associated with the charao project.
** Copyright (C) 2025 MATSUDA Masahiro
**
** This configuration file is licensed under the MIT License.
**===================================================================
** GF180MCU PDK (gf180mcuC) - TT corner
** Source: volare 0fe599b2afb6708d281543108caf8310912f54af (2024.08.17)

.inc '../../../../sample_src/gf180mcuC/libs.tech/ngspice/design.ngspice'
.lib '../../../../sample_src/gf180mcuC/libs.tech/ngspice/sm141064.ngspice' typical
.lib '../../../../sample_src/gf180mcuC/libs.tech/ngspice/sm141064.ngspice' diode_typical
